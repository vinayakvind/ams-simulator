* Buck-Boost Converter - Inverting DC-DC Converter
* Converts 12V input to -12V output (inverted)
* Can also produce |Vout| > Vin or |Vout| < Vin
* Switching frequency: 100kHz

* Power Supply
Vin input 0 DC 12V

* Input capacitor
Cin input 0 10u

* MOSFET Switch (connects input to inductor during ON)
M1 input sw_node gate 0 NMOS W=20u L=0.18u

* Gate drive signal (50% duty cycle for |Vout| = Vin)
Vgate gate 0 PULSE(0 10 0 10n 10n 5u 10u)

* Inductor (100uH)
L1 sw_node 0 100u IC=1

* Freewheeling diode (conducts during OFF, charges negative output)
D1 output sw_node DFAST

* Output capacitor (100uF)
Cout output 0 100u IC=-12

* Load resistor (12 ohm = 1A at 12V)
Rload output 0 12

* MOSFET Model
.MODEL NMOS NMOS (VTO=0.7 KP=110u LAMBDA=0.04)

* Diode Model
.MODEL DFAST D (IS=1e-14 RS=0.01 BV=50)

* Transient Analysis
.TRAN 100n 1m

* Measurements
.MEASURE TRAN Vout_avg AVG V(output) FROM=800u TO=1m
.MEASURE TRAN Vout_ripple PP V(output) FROM=800u TO=1m

* Expected Results:
* - Output voltage: ~-12V average (inverted)
* - At D=0.5: |Vout| = Vin * D/(1-D) = 12V
* - Output ripple: ~100mV peak-to-peak

.END

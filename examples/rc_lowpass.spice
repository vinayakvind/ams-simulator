* RC Low-Pass Filter
* Cutoff frequency = 1/(2*pi*R*C) = 159 Hz

R1 in out 1k
C1 out 0 1u
V1 in 0 AC 1

.AC DEC 10 1 1MEG
.END

* SPI Slave Controller - Digital Block
* 4-wire SPI: SCLK, MOSI, MISO, CS_N
* 8-bit address, 8-bit data register interface
.SUBCKT SPI_CONTROLLER SCLK MOSI MISO CS_N VDD GND
+ REG_ADDR[7:0] REG_WDATA[7:0] REG_RDATA[7:0]
+ REG_WR REG_RD CLK RST_N

* ---- Verilog behavioral description ----
* module spi_slave (
*   input  wire       sclk,
*   input  wire       mosi,
*   output reg        miso,
*   input  wire       cs_n,
*   output reg  [7:0] reg_addr,
*   output reg  [7:0] reg_wdata,
*   input  wire [7:0] reg_rdata,
*   output reg        reg_wr,
*   output reg        reg_rd,
*   input  wire       clk,
*   input  wire       rst_n
* );
*
* reg [4:0] bit_cnt;
* reg [7:0] shift_in;
* reg [7:0] shift_out;
* reg       cmd_phase;  // 0=address, 1=data
* reg       rw_bit;     // 0=write, 1=read
*
* always @(posedge sclk or negedge cs_n) begin
*   if (!cs_n) begin
*     shift_in <= {shift_in[6:0], mosi};
*     bit_cnt <= bit_cnt + 1;
*   end
* end
*
* always @(negedge sclk) begin
*   miso <= shift_out[7];
*   shift_out <= {shift_out[6:0], 1'b0};
* end
*
* always @(posedge cs_n) begin
*   bit_cnt <= 0;
*   cmd_phase <= 0;
*   reg_wr <= 0;
*   reg_rd <= 0;
* end
*
* endmodule

* Gate-level placeholder for simulation
* (Full RTL in digital/ directory)
.ENDS SPI_CONTROLLER

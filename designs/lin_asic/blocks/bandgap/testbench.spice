* Testbench: bandgap
* Auto-generated by AMS Design Framework

.include bandgap.spice

* Technology models
.MODEL NMOS_3P3 NMOS (VTO=0.5 KP=120u LAMBDA=0.01 GAMMA=0.4 PHI=0.8)
.MODEL PMOS_3P3 PMOS (VTO=-0.5 KP=40u LAMBDA=0.01 GAMMA=0.4 PHI=0.8)
.MODEL PMOS_HV PMOS (VTO=-0.8 KP=20u LAMBDA=0.005)
.MODEL NPN_VERT NPN (IS=1e-15 BF=100 BR=1)

* Supplies
V_VDD VDD 0 DC 3.3
V_GND_REF GND_REF 0 DC 0

* Enable
V_EN EN 0 DC 3.3

* DUT instantiation
X_DUT VDD VREF GND EN BANDGAP

* Analysis
.OP

.end
